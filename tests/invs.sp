* 32-stage inverter chain transient test (SIN -> quasi-square)
* Nodes:
*   200: VDD
*   101: VIN
*   102..133: stage outputs (32 stages)

Vdd 200 0 DC 3
* 0~3V 正弦，经过反相器链会被“整形”为近似方波
Vin 101 0 DC 1.5 SIN 1.5 1.5 10e6 0 0

* Models: 注意你当前 parser 里“PMOS 由 VT<0 判定”，所以 PMOS 的 VT 要写成负数 :contentReference[oaicite:2]{index=2}
.MODEL 1 VT -0.7 MU 4e-2 COX 2.5e-3 LAMBDA 0.05 CJ0 1e-12
.MODEL 2 VT  0.7 MU 6e-2 COX 2.5e-3 LAMBDA 0.05 CJ0 1e-12

* Inverter sizes
* PMOS: W=60u L=0.25u  (model 1)
* NMOS: W=30u L=0.25u  (model 2)

* ---- stage 1 (out=102, in=101)
Mp1 102 101 200 p 60e-6 0.25e-6 1
Mn1 102 101 0   n 30e-6 0.25e-6 2
C1  102 0  20e-15

* ---- stage 2
Mp2 103 102 200 p 60e-6 0.25e-6 1
Mn2 103 102 0   n 30e-6 0.25e-6 2
C2  103 0  20e-15

* ---- stage 3
Mp3 104 103 200 p 60e-6 0.25e-6 1
Mn3 104 103 0   n 30e-6 0.25e-6 2
C3  104 0  20e-15

* ---- stage 4
Mp4 105 104 200 p 60e-6 0.25e-6 1
Mn4 105 104 0   n 30e-6 0.25e-6 2
C4  105 0  20e-15

* ---- stage 5
Mp5 106 105 200 p 60e-6 0.25e-6 1
Mn5 106 105 0   n 30e-6 0.25e-6 2
C5  106 0  20e-15

* ---- stage 6
Mp6 107 106 200 p 60e-6 0.25e-6 1
Mn6 107 106 0   n 30e-6 0.25e-6 2
C6  107 0  20e-15

* ---- stage 7
Mp7 108 107 200 p 60e-6 0.25e-6 1
Mn7 108 107 0   n 30e-6 0.25e-6 2
C7  108 0  20e-15

* ---- stage 8
Mp8 109 108 200 p 60e-6 0.25e-6 1
Mn8 109 108 0   n 30e-6 0.25e-6 2
C8  109 0  20e-15

* ---- stage 9
Mp9 110 109 200 p 60e-6 0.25e-6 1
Mn9 110 109 0   n 30e-6 0.25e-6 2
C9  110 0  20e-15

* ---- stage 10
Mp10 111 110 200 p 60e-6 0.25e-6 1
Mn10 111 110 0   n 30e-6 0.25e-6 2
C10  111 0  20e-15

* ---- stage 11
Mp11 112 111 200 p 60e-6 0.25e-6 1
Mn11 112 111 0   n 30e-6 0.25e-6 2
C11  112 0  20e-15

* ---- stage 12
Mp12 113 112 200 p 60e-6 0.25e-6 1
Mn12 113 112 0   n 30e-6 0.25e-6 2
C12  113 0  20e-15

* ---- stage 13
Mp13 114 113 200 p 60e-6 0.25e-6 1
Mn13 114 113 0   n 30e-6 0.25e-6 2
C13  114 0  20e-15

* ---- stage 14
Mp14 115 114 200 p 60e-6 0.25e-6 1
Mn14 115 114 0   n 30e-6 0.25e-6 2
C14  115 0  20e-15

* ---- stage 15
Mp15 116 115 200 p 60e-6 0.25e-6 1
Mn15 116 115 0   n 30e-6 0.25e-6 2
C15  116 0  20e-15

* ---- stage 16
Mp16 117 116 200 p 60e-6 0.25e-6 1
Mn16 117 116 0   n 30e-6 0.25e-6 2
C16  117 0  20e-15

* ---- stage 17
Mp17 118 117 200 p 60e-6 0.25e-6 1
Mn17 118 117 0   n 30e-6 0.25e-6 2
C17  118 0  20e-15

* ---- stage 18
Mp18 119 118 200 p 60e-6 0.25e-6 1
Mn18 119 118 0   n 30e-6 0.25e-6 2
C18  119 0  20e-15

* ---- stage 19
Mp19 120 119 200 p 60e-6 0.25e-6 1
Mn19 120 119 0   n 30e-6 0.25e-6 2
C19  120 0  20e-15

* ---- stage 20
Mp20 121 120 200 p 60e-6 0.25e-6 1
Mn20 121 120 0   n 30e-6 0.25e-6 2
C20  121 0  20e-15

* ---- stage 21
Mp21 122 121 200 p 60e-6 0.25e-6 1
Mn21 122 121 0   n 30e-6 0.25e-6 2
C21  122 0  20e-15

* ---- stage 22
Mp22 123 122 200 p 60e-6 0.25e-6 1
Mn22 123 122 0   n 30e-6 0.25e-6 2
C22  123 0  20e-15

* ---- stage 23
Mp23 124 123 200 p 60e-6 0.25e-6 1
Mn23 124 123 0   n 30e-6 0.25e-6 2
C23  124 0  20e-15

* ---- stage 24
Mp24 125 124 200 p 60e-6 0.25e-6 1
Mn24 125 124 0   n 30e-6 0.25e-6 2
C24  125 0  20e-15

* ---- stage 25
Mp25 126 125 200 p 60e-6 0.25e-6 1
Mn25 126 125 0   n 30e-6 0.25e-6 2
C25  126 0  20e-15

* ---- stage 26
Mp26 127 126 200 p 60e-6 0.25e-6 1
Mn26 127 126 0   n 30e-6 0.25e-6 2
C26  127 0  20e-15

* ---- stage 27
Mp27 128 127 200 p 60e-6 0.25e-6 1
Mn27 128 127 0   n 30e-6 0.25e-6 2
C27  128 0  20e-15

* ---- stage 28
Mp28 129 128 200 p 60e-6 0.25e-6 1
Mn28 129 128 0   n 30e-6 0.25e-6 2
C28  129 0  20e-15

* ---- stage 29
Mp29 130 129 200 p 60e-6 0.25e-6 1
Mn29 130 129 0   n 30e-6 0.25e-6 2
C29  130 0  20e-15

* ---- stage 30
Mp30 131 130 200 p 60e-6 0.25e-6 1
Mn30 131 130 0   n 30e-6 0.25e-6 2
C30  131 0  20e-15

* ---- stage 31
Mp31 132 131 200 p 60e-6 0.25e-6 1
Mn31 132 131 0   n 30e-6 0.25e-6 2
C31  132 0  20e-15

* ---- stage 32 (final out=133)
Mp32 133 132 200 p 60e-6 0.25e-6 1
Mn32 133 132 0   n 30e-6 0.25e-6 2
C32  133 0  50e-15
Rterm 133 0  50k

.OP
.TRAN 1e-10 5e-7 0

* 输出到 CSV（你现在的 CSV 表头是 "time,V(...)" :contentReference[oaicite:3]{index=3}
.PLOTNV 101
.PLOTNV 102
.PLOTNV 109
.PLOTNV 117
.PLOTNV 133

.PROBE tran V(101) V(133)
